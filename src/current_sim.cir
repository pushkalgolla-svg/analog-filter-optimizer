* Parameterized 2nd-Order Active Sallen-Key Low-Pass Filter Template
Vin in 0 ac 1.0

* Sallen-Key Filter Network (2nd-Order)
R1 in n1 9.82939469e+04
R2 n1 inp 5.19596860e+04
C1 n1 out 3.29165182e-09
C2 inp 0 1.51470793e-09

* Unity-Gain Op-Amp Buffer (Voltage-Controlled Voltage Source, AOL = 100,000)
Eop out 0 inp out 1e5

.control
set wr_singlescale
ac dec 100 10 100k
let vdb_out = db(v(out))
wrdata output/sim_data.txt vdb_out
quit
.endc
.end
