* Parameterized 2nd-Order Active Sallen-Key High-Pass Filter
* Active Amplifier Mode: {MODEL_MODE_DESC}
{MODEL_INCLUDE}

* Independent AC Input Voltage Source
Vin in 0 ac 1.0

* Power Supply Rails and Decoupling Network
{POWER_SUPPLY_BLOCK}

* Sallen-Key 2nd-Order High-Pass Filter Network
C1 in n1 {C1_VAL}
C2 n1 inp {C2_VAL}
R1 n1 out {R1_VAL}
R2 inp 0 {R2_VAL}

* Operational Amplifier Subsystem
{OPAMP_BLOCK}

* Control block for AC frequency sweep and automated data export
.control
set wr_singlescale
ac dec 100 {F_START} {F_STOP}
let vdb_out = db(v(out))
wrdata {OUTPUT_DATA_FILE} vdb_out
quit
.endc
.end
