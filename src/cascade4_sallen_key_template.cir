* Parameterized 4th-Order Cascaded Sallen-Key Butterworth Low-Pass Filter
* Active Amplifier Mode: {MODEL_MODE_DESC}
{MODEL_INCLUDE}

* Independent AC Input Voltage Source
Vin in 0 ac 1.0

* Power Supply Rails and Decoupling Network
{POWER_SUPPLY_BLOCK}

* Stage 1 (Biquad 1: Q1 = 0.5412)
R1_1 in n1 {R1_1_VAL}
R2_1 n1 inp1 {R2_1_VAL}
C1_1 n1 out1 {C1_1_VAL}
C2_1 inp1 0 {C2_1_VAL}

* Stage 2 (Biquad 2: Q2 = 1.3065)
R1_2 out1 n2 {R1_2_VAL}
R2_2 n2 inp2 {R2_2_VAL}
C1_2 n2 out2 {C1_2_VAL}
C2_2 inp2 0 {C2_2_VAL}

* Operational Amplifier Subsystem (Dual-Channel Unit A & Unit B)
{OPAMP_BLOCK}

* Control block for AC frequency sweep and automated data export
.control
set wr_singlescale
ac dec 100 {F_START} {F_STOP}
let vdb_out = db(v(out2))
wrdata {OUTPUT_DATA_FILE} vdb_out
quit
.endc
.end
